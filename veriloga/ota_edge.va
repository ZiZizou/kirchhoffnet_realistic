`include "constants.vams"
`include "disciplines.vams"
`include "hrknet_constants.vams"
// Single-ended equivalent of the legacy two-terminal edge and HW differential pair.
module ota_edge(src,dst);
  inout src,dst; electrical src,dst;
  parameter integer mode=0; // 0 legacy, 1 hw
  parameter integer ab_mode=0; // 0 legacy A/B, 1 ratio, 2 differential, 3 cap divider
  parameter real A=1.0, B=1.0, Ahat=1.0, Bhat=1.0;
  parameter integer cap_code_a=7, cap_code_b=7, cap_bits=3;
  parameter real cap_rmax=2.0;
  parameter real s=1.0, theta=0.0, gm=1.0, Isat=1.0;
  parameter real z_gate=1.0, sigma_z=1.0, vca=1.0, gln=1.0;
  parameter real Vcm=`HRK_VCM, Vu=`HRK_VU, vth=0.03086;
  parameter real gate_width=0.02, x_max=4.0, floor_term=0.01;
  parameter real g_hw=1.0, g_min=0.0625, f_ic=1.0;
  parameter real lambda_v=0.0;
  real xs,xd,u,t,aa,bb,gate,ip,inn,vtop_d,vbot_d,vtop_s,vbot_s;
  analog begin
    xs=(V(src)-Vcm)/Vu; xd=(V(dst)-Vcm)/Vu;
    aa=A; bb=B;
    if (mode==1 && (ab_mode==2)) begin aa=1.0; bb=1.0; end
    if (mode==1 && (ab_mode==3)) begin
      aa=1.0/cap_rmax+(1.0-1.0/cap_rmax)*cap_code_a/(2.0**cap_bits-1.0);
      bb=1.0/cap_rmax+(1.0-1.0/cap_rmax)*cap_code_b/(2.0**cap_bits-1.0);
    end
    if (mode==1 && (ab_mode==1)) begin aa=A; bb=B; end
    if (mode==1)
      u=gm*g_hw*f_ic*gln*(s*(aa*xs-bb*xd)+theta);
    else
      u=gm*(s*(aa*xs-bb*xd)+theta);
    t=tanh(u);
    if (mode==0) begin
      gate=z_gate*sigma_z*vca;
      gate=gate/(1.0+limexp(-(x_max-abs(xs))/gate_width));
      gate=gate/(1.0+limexp(-(x_max-abs(xd))/gate_width));
      I(src,dst) <+ Isat*gate*(t+floor_term*u)*`HRK_IU;
    end else begin
      // Real current legs. Compliance is computed independently at each node;
      // unlike the legacy edge this need not be a conservative two-terminal branch.
      ip=0.5*Isat*z_gate*sigma_z*vca*gln*(1.0+t);
      inn=0.5*Isat*z_gate*sigma_z*vca*gln*(1.0-t);
      vtop_d=`HRK_VDD-V(dst); vbot_d=V(dst);
      vtop_s=`HRK_VDD-V(src); vbot_s=V(src);
      I(dst) <+ (ip*(1.0-lambda_v*(V(dst)-Vcm))*(1.0-limexp(-vtop_d/vth))
                    - inn*(1.0+lambda_v*(V(dst)-Vcm))*(1.0-limexp(-vbot_d/vth)))*`HRK_IU;
      I(src) <+ (inn*(1.0-lambda_v*(V(src)-Vcm))*(1.0-limexp(-vtop_s/vth))
                    - ip*(1.0+lambda_v*(V(src)-Vcm))*(1.0-limexp(-vbot_s/vth)))*`HRK_IU;
    end
  end
endmodule
