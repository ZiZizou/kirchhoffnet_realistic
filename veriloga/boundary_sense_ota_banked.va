`include "constants.vams"
`include "disciplines.vams"
`include "hrknet_constants.vams"
// Seven-bank boundary/sense OTA; nearest-volt stage rounded/clamped [0,6].
module boundary_sense_ota_banked(src,dst,stage,en);
  inout src,dst; input stage,en; electrical src,dst,stage,en;
  parameter real gm[0:6]='{1,1,1,1,1,1,1},Isat[0:6]='{1,1,1,1,1,1,1},G[0:6]='{0,0,0,0,0,0,0};
  parameter real A[0:6]='{1,1,1,1,1,1,1},B[0:6]='{1,1,1,1,1,1,1},theta[0:6]='{0,0,0,0,0,0,0},s[0:6]='{1,1,1,1,1,1,1};
  parameter real z_gate[0:6]='{1,1,1,1,1,1,1},alpha=0.01,Vcm=`HRK_VCM,Vu=`HRK_VU,x_max=4.0,gate_width=0.02,en_width=0.01;
  integer k; real xs,xd,u,gate,eg;
  analog begin
    k=integer'(floor(V(stage)+0.5)); if(k<0) k=0; if(k>6) k=6;
    xs=(V(src)-Vcm)/Vu; xd=(V(dst)-Vcm)/Vu; u=gm[k]*(s[k]*(A[k]*xs-B[k]*xd)+theta[k]);
    gate=z_gate[k]; gate=gate/(1.0+limexp(-(x_max-abs(xs))/gate_width)); gate=gate/(1.0+limexp(-(x_max-abs(xd))/gate_width));
    eg=1.0/(1.0+limexp(-(V(en)-0.5)/en_width));
    I(dst) <+ -eg*(Isat[k]*(tanh(u)+alpha*u)*gate+G[k]*(xs-xd)*z_gate[k])*`HRK_IU;
  end
endmodule
