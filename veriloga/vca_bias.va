`include "constants.vams"
`include "disciplines.vams"
`include "hrknet_constants.vams"
module vca_bias(u0,u1,u2,u3,gain);
  input u0,u1,u2,u3; output gain; electrical u0,u1,u2,u3,gain;
  parameter real rank=3.0, zeta_max=4.0;
  parameter real w0=0.0,w1=0.0,w2=0.0,w3=0.0,bias=0.0;
  real z;
  analog begin
    z=bias+w0*V(u0)+w1*V(u1)+w2*V(u2)+w3*V(u3);
    // torch gating.vca.vca_edge_gain returns 2*sigmoid(logits).
    V(gain) <+ 2.0/(1.0+limexp(-z));
  end
endmodule
