`include "constants.vams"
`include "disciplines.vams"
`include "hrknet_constants.vams"
// Frozen-read legacy OTA: evaluate from held samples, inject on live state nodes.
module ota_edge_sampled(src_hold,dst_hold,src_live,dst_live);
  input src_hold,dst_hold; inout src_live,dst_live;
  electrical src_hold,dst_hold,src_live,dst_live;
  parameter integer mode=0,ab_mode=0;
  parameter real A=1.0,B=1.0,s=1.0,theta=0.0,gm=1.0,Isat=1.0;
  parameter integer cap_code_a=7,cap_code_b=7,cap_bits=3;
  parameter real cap_rmax=2.0,g_hw=1.0,f_ic=1.0;
  parameter real z_gate=1.0,sigma_z=1.0,vca=1.0;
  parameter real Vcm=`HRK_VCM,Vu=`HRK_VU;
  parameter real x_max=4.0,gate_width=0.02,floor_term=0.01;
  real xs,xd,u,gate,aa,bb;
  analog begin
    xs=(V(src_hold)-Vcm)/Vu; xd=(V(dst_hold)-Vcm)/Vu;
    aa=A; bb=B;
    if (mode==1 && ab_mode==2) begin aa=1.0; bb=1.0; end
    if (mode==1 && ab_mode==3) begin
      aa=1.0/cap_rmax+(1.0-1.0/cap_rmax)*cap_code_a/(2.0**cap_bits-1.0);
      bb=1.0/cap_rmax+(1.0-1.0/cap_rmax)*cap_code_b/(2.0**cap_bits-1.0);
    end
    if (mode==1) u=gm*g_hw*f_ic*(s*(aa*xs-bb*xd)+theta);
    else u=gm*(s*(aa*xs-bb*xd)+theta);
    gate=z_gate*sigma_z*vca;
    gate=gate/(1.0+limexp(-(x_max-abs(xs))/gate_width));
    gate=gate/(1.0+limexp(-(x_max-abs(xd))/gate_width));
    I(src_live,dst_live) <+ Isat*gate*(tanh(u)+floor_term*u)*`HRK_IU;
  end
endmodule
