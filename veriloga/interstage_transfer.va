`include "constants.vams"
`include "disciplines.vams"
`include "hrknet_constants.vams"
module interstage_transfer(in,out,enable);
  input in,enable; output out; electrical in,out,enable;
  parameter real w1=1.0,w2=0.0,w3=0.0,vth=0.0,x_hard=5.714,Vcm=`HRK_VCM,Vu=`HRK_VU;
  parameter real Ron=1e3,Roff=1e12,smooth_width=1e-4,enable_width=0.01;
  real x,y,relu_x,g_on;
  analog begin
    x=(V(in)-Vcm)/Vu;
    // Smooth ReLU and rail clamp avoid nonphysical hard discontinuities. At
    // smooth_width -> 0 these converge to the torch full-transfer equation.
    relu_x=0.5*((x-vth)+sqrt((x-vth)*(x-vth)+smooth_width*smooth_width));
    y=w1*x+w2*tanh(x)+w3*relu_x;
    y=x_hard*tanh(y/x_hard);
    g_on=1.0/Roff+(1.0/Ron-1.0/Roff)/(1.0+limexp(-(V(enable)-0.5)/enable_width));
    // During the transfer phase the capacitor is rewritten toward its new
    // value; outside the phase only the tiny off conductance remains.
    I(out) <+ g_on*(V(out)-(Vcm+Vu*y));
  end
endmodule
